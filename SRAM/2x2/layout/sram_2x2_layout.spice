* NGSPICE file created from sram_2x2_layout.ext - technology: scmos

.subckt sram_cell_layout BLB VDD WL VSS BL
M1000 Q WL BL VSS nfet w=1.8u l=0.6u
+  ad=5.67p pd=7.5u as=5.4p ps=9.6u
M1001 Q QB VSS VSS nfet w=3.6u l=0.6u
+  ad=5.67p pd=7.5u as=8.64p ps=12u
M1002 Q QB VDD VDD pfet w=3.6u l=0.6u
+  ad=8.64p pd=12u as=8.64p ps=12u
M1003 VSS Q QB VSS nfet w=3.6u l=0.6u
+  ad=8.64p pd=12u as=5.67p ps=7.5u
M1004 QB WL BLB VSS nfet w=1.8u l=0.6u
+  ad=5.67p pd=7.5u as=5.4p ps=9.6u
M1005 VDD Q QB VDD pfet w=3.6u l=0.6u
+  ad=8.64p pd=12u as=8.64p ps=12u
.ends

.subckt sram_2x2_layout VDD WL_0 WL_1 GND BL_0 BLB_0 BLB_1 BL_1
Xsram_cell_layout_0 BL_1 VDD WL_0 GND BLB_1 sram_cell_layout
Xsram_cell_layout_1 BL_0 VDD WL_0 GND BLB_0 sram_cell_layout
Xsram_cell_layout_2 BLB_0 VDD WL_1 GND BL_0 sram_cell_layout
Xsram_cell_layout_3 BLB_1 VDD WL_1 GND BL_1 sram_cell_layout
.ends
